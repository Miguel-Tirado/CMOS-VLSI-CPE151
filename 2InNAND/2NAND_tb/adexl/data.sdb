ADE simulation setup
Run mode: Single Run, Sweeps and Corners
Tests:
  2InNAND:2NAND_tb:1: 2InNAND/2NAND_tb/schematic, simulator spectre
