ADE simulation setup
Run mode: Single Run, Sweeps and Corners
Tests:
  Project2_NAND:3nand_tb:1: Project2_NAND/3nand_tb/schematic, simulator spectre
