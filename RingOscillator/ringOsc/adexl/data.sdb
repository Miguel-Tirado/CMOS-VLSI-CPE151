ADE simulation setup
Run mode: Single Run, Sweeps and Corners
Tests:
  RingOscillator:ringOsc:1: RingOscillator/ringOsc/schematic, simulator spectre
