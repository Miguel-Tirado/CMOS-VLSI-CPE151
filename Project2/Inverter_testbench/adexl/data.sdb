ADE simulation setup
Run mode: Single Run, Sweeps and Corners
Tests:
  Project1:Inverter_testbench:1: Project1/Inverter_testbench/schematic, simulator spectre
